* alpha5e-3beta5e-5_100nA1to200hz200s100us.cir
* Generated by LTspice 26.0.2 for Windows.
V1 VDD 0 18
V2 VSS 0 -18
C1 in1 N001 {C_val}
R1 N001 N005 {R1_val}
R2 N005 N002 {R2_val}
R3 N002 N007 {R3_val}
C2 N007 0 {C_val}
C3 out1 N003 {C_val}
R4 N003 N006 {R4_val}
R5 N006 N004 {R5_val}
R6 N004 N008 {R6_val}
C4 N008 0 {C_val}
Rn1 out1 in1 R=Rn(1,V(in1,out1))
B1 0 in1 I=I0_val*sin(2*pi*(f1*time + 0.5*(f2-f1)/T * time*time))
XU1 in1 N005 VDD VSS N002 level4 Avol={Avol_val} GBW={GBW_val} Slew={Slew_val} Ilimit={Ilimit_val} Rail={Rail_val} Vos={Vos_val} Phimargin={Phimargin_val} En={En_val} Enk={Enk_val} In={In_val} Ink={Ink_val} Rin={Rin_val} Ro={Ro_val} Ccm={Ccm_val} Cdiff={Cdiff_val} ;pnba In+)In-)V+)V-)OUT
RBI1 in1 0 {RINbias_val}
XU2 N007 N005 VDD VSS N001 level4 Avol={Avol_val} GBW={GBW_val} Slew={Slew_val} Ilimit={Ilimit_val} Rail={Rail_val} Vos={Vos_val} Phimargin={Phimargin_val} En={En_val} Enk={Enk_val} In={In_val} Ink={Ink_val} Rin={Rin_val} Ro={Ro_val} Ccm={Ccm_val} Cdiff={Cdiff_val} ;pnba In+)In-)V+)V-)OUT
XU3 out1 N006 VDD VSS N004 level4 Avol={Avol_val} GBW={GBW_val} Slew={Slew_val} Ilimit={Ilimit_val} Rail={Rail_val} Vos={Vos_val} Phimargin={Phimargin_val} En={En_val} Enk={Enk_val} In={In_val} Ink={Ink_val} Rin={Rin_val} Ro={Ro_val} Ccm={Ccm_val} Cdiff={Cdiff_val} ;pnba In+)In-)V+)V-)OUT
XU4 N008 N006 VDD VSS N003 level4 Avol={Avol_val} GBW={GBW_val} Slew={Slew_val} Ilimit={Ilimit_val} Rail={Rail_val} Vos={Vos_val} Phimargin={Phimargin_val} En={En_val} Enk={Enk_val} In={In_val} Ink={Ink_val} Rin={Rin_val} Ro={Ro_val} Ccm={Ccm_val} Cdiff={Cdiff_val} ;pnba In+)In-)V+)V-)OUT
* .ac oct 100 10 100
.tran 0 200 0 0.1m
.param C_val = 2.2n
.param R1_val = 15k
.param R2_val = 100
.param R3_val = 18k
.param R4_val = 7.15k
.param R5_val = 10
.param R6_val = 10.2k
.func Rn(n,v) {1k/(alpha_val+beta_val*v*v)}
.param alpha_val=0.005
.param beta_val=5e-05
.param RINbias_val = 2meg
.param ROUTbias_val = 2meg
.param I0_val=1e-07
.param T = 200
.param f1=1
.param f2=200
.option method=gear
.param Avol_val = 100k
.param GBW_val = 4meg
.param Slew_val = 13meg
.param Ilimit_val = 10m
.param Rail_val = 0
.param Vos_val = 0
.param Phimargin_val = 56
.param En_val = 0
.param Enk_val = 0
.param In_val = 0
.param Ink_val = 0
.param Rin_val = 1T
.param Ro_val = 150
.param Ccm_val = 0
.param Cdiff_val = 0
.lib "../models/UniversalOpAmp4.lib"
.backanno
.save V(in1) V(out1) I(B1) V(N001) V(N002) V(N003) V(N004) I(R1) I(R2) I(R3) I(R4) I(R5) I(R6) I(C1) I(C3)
.options plotwinsize=0
.end
